* Cermin arus 1:1, L = 0.5
.param mc_switch=0
.option scale=1.0u
.include modelcard.skywater

* arus rujukan 20 uA mengalir ke transistor diod xm1
iref vdd d1 20u
xm1 d1  d1 0 0 sky130_fd_pr__nfet_01v8 w=1  l=0.5
xm2 out d1 0 0 sky130_fd_pr__nfet_01v8 w=1 l=0.5

vdd vdd 0 1.8
* vo sebagai beban: arus keluaran ialah -i(vo)
vo  out 0 0.9

.dc vo 0 1.8 0.01
.end
