* SKY130 op-amp dua peringkat dengan pampasan Miller - gelung terbuka
.param mc_switch=0
.option scale=1.0u
.include modelcard.skywater

* peringkat 1: pasangan NMOS + cermin PMOS
xm1 d1  inn tail 0   sky130_fd_pr__nfet_01v8 w=3 l=0.5
xm2 o1  inp tail 0   sky130_fd_pr__nfet_01v8 w=3 l=0.5
xm3 d1  d1  vdd  vdd sky130_fd_pr__pfet_01v8 w=3 l=0.5
xm4 o1  d1  vdd  vdd sky130_fd_pr__pfet_01v8 w=3 l=0.5
* peringkat 2: PMOS common-source dengan beban sumber arus ideal
xm6 out o1  vdd  vdd sky130_fd_pr__pfet_01v8 w=7 l=0.5
ib2 out 0 60u
iss tail 0 20u
* pampasan Miller dan beban
cc  o1  out 4p
cl  out 0 1p

vdd vdd 0 1.8
* DC: maklum balas unit melalui induktor besar; AC: inn dibumikan melalui kapasitor besar
lfb out inn 1G
cfb inn 0 1G
vinp inp 0 dc 0.9 ac 1

.ac dec 20 1 10G
.end
