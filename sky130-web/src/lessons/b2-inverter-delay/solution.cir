* SKY130 inverter - transient (delay)
.param mc_switch=0
.option scale=1.0u
.include modelcard.skywater

xm1 out in 0   0   sky130_fd_pr__nfet_01v8 w=1 l=0.15
xm2 out in vdd vdd sky130_fd_pr__pfet_01v8 w=3 l=0.15
cl  out 0 20f

vdd vdd 0 1.8
vin in  0 pulse(0 1.8 1n 0.1n 0.1n 5n 10n)

.tran 0.01n 30n
.end
