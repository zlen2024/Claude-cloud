* SKY130 common-source dengan beban sumber arus PMOS - AC
.param mc_switch=0
.option scale=1.0u
.include modelcard.skywater

xm1 out in 0   0   sky130_fd_pr__nfet_01v8 w=3 l=0.5
* PMOS sebagai sumber arus: gate dibias tetap (Vsg = 1.0 V)
xm2 out bp vdd vdd sky130_fd_pr__pfet_01v8 w=3 l=0.5
cl  out 0 100f

vdd vdd 0 1.8
vbp bp  0 0.8
vin in  0 dc 0.70 ac 1

.ac dec 20 1 10G
.end
