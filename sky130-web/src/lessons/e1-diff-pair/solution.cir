* SKY130 pasangan pembeza - fungsi pindah isyarat besar
.param mc_switch=0
.option scale=1.0u
.include modelcard.skywater

xm1 o1 in1 tail 0 sky130_fd_pr__nfet_01v8 w=3 l=0.5
xm2 o2 in2 tail 0 sky130_fd_pr__nfet_01v8 w=3 l=0.5
rd1 vdd o1 10k
rd2 vdd o2 10k
* sumber arus ekor ideal (bukan peranti SKY130)
iss tail 0 100u

vdd vdd 0 1.8
vin2 in2 0 0.9
vin1 in1 0 0.9

* sapu input 1 di sekeliling mod sepunya 0.9 V
.dc vin1 0.6 1.2 0.005
.end
