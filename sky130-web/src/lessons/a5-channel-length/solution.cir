* SKY130 NMOS - modulasi panjang saluran (tiga L)
.param mc_switch=0
.option scale=1.0u
.include modelcard.skywater

xm1 d1 g 0 0 sky130_fd_pr__nfet_01v8 w=1 l=0.15
xm2 d2 g 0 0 sky130_fd_pr__nfet_01v8 w=1 l=0.5
xm3 d3 g 0 0 sky130_fd_pr__nfet_01v8 w=1 l=1

vds ds 0 0
* sumber 0V untuk mengukur arus setiap transistor (arus positif = Id)
vm1 ds d1 0
vm2 ds d2 0
vm3 ds d3 0
vg  g  0 1.0

.dc vds 0 1.8 0.01
.end
