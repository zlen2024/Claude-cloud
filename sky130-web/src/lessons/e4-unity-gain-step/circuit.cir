* SKY130 op-amp dalam maklum balas unit - sambutan langkah
.param mc_switch=0
.option scale=1.0u
.include modelcard.skywater

xm1 d1  inn tail 0   sky130_fd_pr__nfet_01v8 w=3 l=0.5
xm2 o1  inp tail 0   sky130_fd_pr__nfet_01v8 w=3 l=0.5
xm3 d1  d1  vdd  vdd sky130_fd_pr__pfet_01v8 w=3 l=0.5
xm4 o1  d1  vdd  vdd sky130_fd_pr__pfet_01v8 w=3 l=0.5
xm6 out o1  vdd  vdd sky130_fd_pr__pfet_01v8 w=7 l=0.5
ib2 out 0 60u
iss tail 0 20u
cc  o1  out 0.1p
cl  out 0 1p

vdd vdd 0 1.8
* maklum balas unit: keluaran terus ke input songsang
rfb out inn 1
* langkah 0.90 V -> 1.00 V pada 20 ns
vin inp 0 pulse(0.9 1.0 20n 1n 1n 2u 4u)

.tran 1n 1.5u
.end
