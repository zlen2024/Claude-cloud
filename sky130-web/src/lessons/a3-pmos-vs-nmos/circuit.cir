* SKY130 NMOS vs PMOS, Vgs = Vsg = 0 hingga 1.8V
.param mc_switch=0
.option scale=1.0u
.include modelcard.skywater

xmn dn g  0   0   sky130_fd_pr__nfet_01v8 w=1 l=0.15
xmp dp gp vdd vdd sky130_fd_pr__pfet_01v8 w=1 l=0.15

vdd vdd 0 1.8
vdn dn 0 1.8
vdp dp 0 0
vg  g  0 0
* gate PMOS = VDD - vg, jadi Vsg PMOS = vg
egp gp 0 vdd g 1

.dc vg 0 1.8 0.01
.end
