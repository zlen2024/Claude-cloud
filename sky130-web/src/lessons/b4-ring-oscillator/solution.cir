* Ring oscillator 5 peringkat
.param mc_switch=0
.option scale=1.0u
.include modelcard.skywater

vdd vdd 0 1.8

xn1 n2 n1 0   0   sky130_fd_pr__nfet_01v8 w=1 l=0.15
xp1 n2 n1 vdd vdd sky130_fd_pr__pfet_01v8 w=3 l=0.15
cp1 n2 0 5f
xn2 n3 n2 0   0   sky130_fd_pr__nfet_01v8 w=1 l=0.15
xp2 n3 n2 vdd vdd sky130_fd_pr__pfet_01v8 w=3 l=0.15
cp2 n3 0 5f
xn3 n4 n3 0   0   sky130_fd_pr__nfet_01v8 w=1 l=0.15
xp3 n4 n3 vdd vdd sky130_fd_pr__pfet_01v8 w=3 l=0.15
cp3 n4 0 5f
xn4 n5 n4 0   0   sky130_fd_pr__nfet_01v8 w=1 l=0.15
xp4 n5 n4 vdd vdd sky130_fd_pr__pfet_01v8 w=3 l=0.15
cp4 n5 0 5f
xn5 n1 n5 0   0   sky130_fd_pr__nfet_01v8 w=1 l=0.15
xp5 n1 n5 vdd vdd sky130_fd_pr__pfet_01v8 w=3 l=0.15
cp5 n1 0 5f

* syarat awal memecahkan simetri supaya ayunan bermula
.ic v(n1)=0 v(n2)=1.8
.tran 5p 20n uic
.end
