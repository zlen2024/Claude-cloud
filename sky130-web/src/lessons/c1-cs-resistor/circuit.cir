* SKY130 common-source amplifier - AC
.param mc_switch=0
.option scale=1.0u
.include modelcard.skywater

xm1 out in 0 0 sky130_fd_pr__nfet_01v8 w=3 l=0.5
rd  vdd out 20k
cl  out 0 100f

vdd vdd 0 1.8
vin in 0 dc 0.8 ac 1

.ac dec 20 1 10G
.end
