* SKY130 NMOS - keluarga Id vs Vds
.param mc_switch=0
.option scale=1.0u
.include modelcard.skywater

xm1 d g 0 0 sky130_fd_pr__nfet_01v8 w=1 l=0.15

vd d 0 0
vg g 0 0

* sapuan dalam: vd, sapuan luar: vg
.dc vd 0 1.8 0.05 vg 0.6 1.8 0.3
.end
